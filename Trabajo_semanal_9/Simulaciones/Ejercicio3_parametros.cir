* TS9 Ejercicio 3: Z11 y Z21 con salida abierta, sin Rg
.param K=10**(-6/20)
Iprueba 0 pin AC 1
L1 pin 0 {31/14} Rser=1n
L2 pin pb {961/48} Rser=0
C2 pin pb {768/961}
L3A pb pout {(1-K)*31/48} Rser=0
L3B pout 0 {K*31/48} Rser=0
.ac dec 1000 0.0001 1000
.options plotwinsize=0
.save V(pin) V(pout) I(Iprueba)
.end
