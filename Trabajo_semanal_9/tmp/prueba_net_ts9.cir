* Prueba .net LC
V1 pin 0 AC 1 Rser=1
L1 pin 0 {31/14} Rser=1n
L2 pin pout {961/48} Rser=0
C2 pin pout {768/961}
L3 pout 0 {31/48} Rser=0
.ac dec 1000 0.0001 1000
.net V(pout) V1 Rin=1 Rout=1
.options plotwinsize=0
.end
