* TS9 Ejercicio 1: Z11 y Z21 con salida abierta
Iprueba 0 pin AC 1
L1 pin 0 {31/14} Rser=1n
L2 pin pout {961/48} Rser=0
C2 pin pout {768/961}
L3 pout 0 {31/48} Rser=0
.ac dec 1000 0.0001 1000
.options plotwinsize=0
.save V(pin) V(pout) I(Iprueba)
.end
