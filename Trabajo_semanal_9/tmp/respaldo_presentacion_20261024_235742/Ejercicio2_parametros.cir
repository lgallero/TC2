* TS9 Ejercicio 2: Z22 y Z12=Z21 con entrada abierta
Vprueba pout 0 AC 1
C3 pin 0 {27/17}
L2 pin pout {289/243} Rser=0
C2 pin pout {27/289}
C1 pout 0 {7/17}
.ac dec 1000 0.0001 1000
.options plotwinsize=0
.save V(pin) V(pout) I(Vprueba)
.end
